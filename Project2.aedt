# Ansys Electronics Desktop project, version 2023.2
materials:
  vacuum: permittivity=1

design HFSSDesign1 (HFSS, HFSS Terminal Network, model units mm)
geometry:
  Box1 [vacuum] = box(corner=(-11.43mm, -5.08mm, 0mm), size=(22.86mm, 10.16mm, 100mm))
boundaries and excitations:
  PerfE1: Perfect E Faces=Box1.face(+x, +y, -x, -y)
  1: Wave Port Faces=Box1.face(-z) WavePortType=Modal NumModes=1 Modes{Mode1{IntLine{(0, 5.08, 0) -> (0, -5.08, 0)} CharImp=Zpi}}
  2: Wave Port Faces=Box1.face(+z) WavePortType=Modal NumModes=1 Modes{Mode1{IntLine{(0, 5.08, 100) -> (0, -5.08, 100)} CharImp=Zpi}}
setups:
  Setup1: HfssDriven Frequency=10GHz MaxDeltaS=0.02 MaximumPasses=6 MinimumPasses=1 MinimumConvergedPasses=1 PercentRefinement=30 BasisOrder=1 PortAccuracy=2 DrivenSolverType="Direct Solver"
    sweep Sweep: 5GHz to 15GHz, 401 points; Type=Interpolating InterpTolerance=0.5 InterpMaxSolns=250 PassivityErrorTolerance=0.0001
    sweep Sweep1: 6GHz to 15GHz, 401 points; Type=Interpolating InterpTolerance=0.5 InterpMaxSolns=250 PassivityErrorTolerance=0.0001
    sweep Sweep2: 7GHz to 15GHz, 401 points; Type=Interpolating InterpTolerance=0.5 InterpMaxSolns=250 PassivityErrorTolerance=0.0001
source amplitudes:
  1:1: 1V 0deg
  2:1: 0V 0deg
field plots:
  Vector_E1: E Field in Box1 on Setup1 : LastAdaptive at Freq=10GHz Phase=0deg
reports:
  S Parameter Plot 1: dB(S(1,1)) vs Freq on Setup1 : Sweep
  S Parameter Plot 2: dB(S(2,1)) vs Freq on Setup1 : Sweep
  S Parameter Plot 3: dB(S(1,2)) vs Freq on Setup1 : Sweep
